* RogueGuard Optical Bench -- Electrical Circuit Analog
* LTspice / ngspice SPICE netlist
* Generated by rogueguard_spice.py (Jalali Lab phase-retrieval stack)
*
* Optical -> Electrical mapping:
*   Laser source       -> V1 (AC voltage source, 1 Vpk)
*   50/50 beam splitter-> T1 (ideal 1:1 transformer)
*   Disperser D1=-600  -> L1 + C1 all-pass (Bessel 2nd order)
*   Disperser D2=-900  -> L2 + C2 all-pass (Bessel 2nd order)
*   InGaAs detector 1  -> R_det1 = 50 ohm (photodetector load)
*   InGaAs detector 2  -> R_det2 = 50 ohm
*   TD-GS DSP          -> .meas directives (post-processing)
*
* Governing law: V = L*dI/dt  (Faraday/Lenz)
*                I = C*dV/dt  (Capacitor constitutive)
*                V = I*R      (Ohm, linear regime only)
* KVL: sum(V_k) = 0 [TRUE for lumped, FALSE above ~GHz self-resonance]
* KCL: sum(I_k) = 0 [TRUE for lumped, FALSE when displacement current matters]
*
.title RogueGuard Optical-Electrical Analog

* ── Source: CW laser at 1572nm modeled as AC source ────────────────
V1  1 0  AC 1 SIN(0 1 1G 0 0)   ; 1 GHz carrier (normalized)

* ── 50/50 beam splitter: ideal 1:1 transformer ─────────────────────
* K-statement couples L_pri and L_sec (coupling coefficient = 1)
L_pri  1 0  1uH
L_sec1 2 0  1uH
L_sec2 3 0  1uH
K_split L_pri L_sec1  1.0   ; arm 1
K_split2 L_pri L_sec2 1.0   ; arm 2

* ── Disperser D1 = -600 ps^2 (arm 1) ───────────────────────────────
* 2nd-order Bessel all-pass: L=0.0004 nH, C=0.5027 pF
* Matched group delay: 37.7 ps at 10 GHz
L1  2 4  0.000377nH
C1  4 0  0.502684pF
R_match1 4 0  50.0   ; impedance matching / Q control

* ── Disperser D2 = -900 ps^2 (arm 2) ───────────────────────────────
* L=0.0006 nH, C=0.7540 pF
L2  3 5  0.000565nH
C2  5 0  0.754026pF
R_match2 5 0  50.0

* ── Detectors (50-ohm InGaAs PIN photodiodes) ───────────────────────
R_det1  4 0  50.0   ; detector arm 1 (I1 = V_det1^2 / R)
R_det2  5 0  50.0   ; detector arm 2 (I2 = V_det2^2 / R)

* ── Analysis ─────────────────────────────────────────────────────────
.ac dec 1000 1Meg 100G   ; AC sweep: 1 MHz to 100 GHz, 1000 pts/decade

* ── Measurements ──────────────────────────────────────────────────────
.meas AC tau_g1 PARAM '-deriv(phase(V(4)),frequency)'
.meas AC tau_g2 PARAM '-deriv(phase(V(5)),frequency)'
.meas AC mag1   PARAM 'mag(V(4))'
.meas AC mag2   PARAM 'mag(V(5))'

* ── SPICE options ─────────────────────────────────────────────────────
.options NUMDGT=8 TRTOL=1 METHOD=Gear
.backanno
.end

* ── How to run ─────────────────────────────────────────────────────────
* LTspice: File -> Open -> select this .cir -> Run (Ctrl+R)
* ngspice (terminal): ngspice rogueguard_circuit.cir
*   then: plot v(4) v(5)
* Export: File -> Export Data -> CSV for Python post-processing
